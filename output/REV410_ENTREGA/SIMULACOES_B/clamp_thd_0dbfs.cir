* Blocker 3 THD Analysis: 0 dBFS max linear swing (1.40 Vp @ 1kHz)
.temp 70
.model 2N3904 NPN (Is=14.34f Bf=80 Vaf=74.03 Ikf=.2847 Xtb=1.5 Br=6.092 Cjc=7.306p Cje=22.01p Rb=10 Rc=1)
.model 2N3906 PNP (Is=1.41f Bf=80 Vaf=18.7 Ikf=80m Xtb=1.5 Br=4.977 Cjc=9.728p Cje=10.68p Rb=20 Rc=2.4)
.model M2N7000 NMOS (Level=3 Vto=3.0 Kp=0.14 Rs=1.2 Rd=1.2 Cgso=60p Cgdo=10p Cbd=40p)

Vva va 0 4.75
Vshunt shunt_en 0 0

R48 va v_ref_hi 12k
R49 v_ref_hi 0 150k
C45 va v_ref_hi 100n
Q9 va v_ref_hi v_bias_hi 2N3904
R50 v_bias_hi 0 6.8k
C46 v_bias_hi 0 100n

R51 va v_ref_lo 150k
R52 v_ref_lo 0 10k
C47 v_ref_lo 0 100n
Q10 0 v_ref_lo v_bias_lo 2N3906
R53 va v_bias_lo 6.8k
C48 v_bias_lo 0 100n

Q11 0 v_bias_hi ainp 2N3906
Q12 va v_bias_lo ainp 2N3904
Q13 0 v_bias_hi ainn 2N3906
Q14 va v_bias_lo ainn 2N3904

M5 ainp shunt_en 0 0 M2N7000
M6 ainn shunt_en 0 0 M2N7000

R27 va adc_bias 13k
R28 adc_bias 0 12k
C40 adc_bias 0 100u
C41 adc_bias 0 100n
R15 ainp adc_bias 100k
R16 ainn adc_bias 100k
C35 ainp 0 100p
C36 ainn 0 100p
C20 ainp ainn 680p
Radc ainp ainn 37k

* Excitação diferencial senoidal centrada em ADC_BIAS (2.28V)
Vin_p drv_p 0 SIN(2.28 1.4 1000)
R18 drv_p ainp 1.5k
Vin_n drv_n 0 SIN(2.28 -1.4 1000)
R20 drv_n ainn 1.5k

.options reltol=1e-5 abstol=1e-11 trtol=1
.control
tran 2u 10m 5m 2u
fourier 1000 (v(ainp)-v(ainn))
quit
.endc
.end
