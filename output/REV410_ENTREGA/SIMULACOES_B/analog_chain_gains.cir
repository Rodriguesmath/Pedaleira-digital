* Analog Chain Gains Verification
* Modelos Padronizados e Conexões Globais
.include /home/rodrigues/Pedaleira-digital/output/auditoria_rev49/SIMULACOES/TL072_TI.301
.model 2N3904 NPN (Is=14.34f Bf=255.9 Vaf=74.03 Ikf=.2847 Xtb=1.5 Br=6.092 Cjc=7.306p Cje=22.01p Rb=10 Rc=1)
.model 2N3906 PNP (Is=1.41f Bf=180.7 Vaf=18.7 Ikf=80m Xtb=1.5 Br=4.977 Cjc=9.728p Cje=10.68p Rb=20 Rc=2.4)
.model D4148 D (Is=2.5n N=1.75 Rs=.6 Cjo=4p Tt=4n)
.model D1N5822 D (Is=50u N=1.05 Rs=0.05 Cjo=200p)
.model DZ4V7 D (Is=1u N=1.5 Rs=10 Bv=4.7 Ibv=1m)
.model M2N7000 NMOS (Level=3 Vto=3.0 Kp=0.14 Rs=1.2 Rd=1.2 Cgso=60p Cgdo=10p Cbd=40p)
.model SW_NO SW (Ron=0.05 Roff=100G Vt=0.55 Vh=0.02)
.model SW_NC SW (Ron=100G Roff=0.05 Vt=0.45 Vh=0.02)

* Subcircuito TL431 Bounded Fisicamente Estável (Ref=1, Anode=2, Cathode=3)
.subckt TL431 ref a k
Gka k a VALUE='(V(k,a) > 0 ? 1 : 0) * ((V(k,a) * 0.1u) + max(0, V(k,a)-2.0) * (0.2u + 50m * 0.5 * (1 + tanh((V(ref,a)-2.495)/0.005))))'
Rka k a 10Meg
Rra ref a 10Meg
Cka k a 10p
.ends

Vraw raw 0 12.0
Vref_op vref_op 0 6.0

* U1A (Buffer Guitarra: Seguidor)
Vin_u1a in_u1a 0 DC 6.0 AC 1.0 SIN(6.0 0.5 1k)
XU1A in_u1a out_u1a raw 0 out_u1a TL072
Rload_u1a out_u1a 0 100k

* U3A (Driver ADC Fase Positiva: Seguidor)
XU3A out_u1a out_u3a raw 0 out_u3a TL072
Rload_u3a out_u3a 0 100k

* U3B (Driver ADC Fase Negativa: Inversor com ganho -R19/R24 = -10k/10k)
R24 out_u1a in_u3b_n 10k
R19 in_u3b_n out_u3b 10k
XU3B vref_op in_u3b_n raw 0 out_u3b TL072
Rload_u3b out_u3b 0 100k

* U1B (Receptor Diferencial DAC: ganho 49.9k / 100k = 0.4990)
Vdac_p dac_p 0 DC 2.5 AC 0.5 0
Vdac_n dac_n 0 DC 2.5 AC 0.5 180
R1 dac_p u1b_p 100k
R2 u1b_p vref_op 49.9k
R7 dac_n u1b_n 100k
R8 u1b_n out_u1b 49.9k
XU1B u1b_p u1b_n raw 0 out_u1b TL072
Rload_u1b out_u1b 0 100k

.control
ac dec 5 100 10k
wrdata /home/rodrigues/Pedaleira-digital/output/REV410_ENTREGA/SIMULACOES_B/analog_chain_gains.txt v(out_u1a) v(out_u3a) v(out_u3b) v(out_u1b)
quit
.endc
.end
