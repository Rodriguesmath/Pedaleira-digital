* BAT85 Failure Baseline Comparison
.temp 27
* Modelos Padronizados e Conexões Globais
.include /home/rodrigues/Pedaleira-digital/output/auditoria_rev49/SIMULACOES/TL072_TI.301
.model 2N3904 NPN (Is=14.34f Bf=255.9 Vaf=74.03 Ikf=.2847 Xtb=1.5 Br=6.092 Cjc=7.306p Cje=22.01p Rb=10 Rc=1)
.model 2N3906 PNP (Is=1.41f Bf=180.7 Vaf=18.7 Ikf=80m Xtb=1.5 Br=4.977 Cjc=9.728p Cje=10.68p Rb=20 Rc=2.4)
.model D4148 D (Is=2.5n N=1.75 Rs=.6 Cjo=4p Tt=4n)
.model D1N5822 D (Is=50u N=1.05 Rs=0.05 Cjo=200p)
.model DZ4V7 D (Is=1u N=1.5 Rs=10 Bv=4.7 Ibv=1m)
.model M2N7000 NMOS (Level=3 Vto=3.0 Kp=0.14 Rs=1.2 Rd=1.2 Cgso=60p Cgdo=10p Cbd=40p)
.model SW_NO SW (Ron=0.05 Roff=100G Vt=0.55 Vh=0.02)
.model SW_NC SW (Ron=100G Roff=0.05 Vt=0.45 Vh=0.02)

* Subcircuito TL431 Bounded Fisicamente Estável (Ref=1, Anode=2, Cathode=3)
.subckt TL431 ref a k
Gka k a VALUE='(V(k,a) > 0 ? 1 : 0) * ((V(k,a) * 0.1u) + max(0, V(k,a)-2.0) * (0.2u + 50m * 0.5 * (1 + tanh((V(ref,a)-2.495)/0.005))))'
Rka k a 10Meg
Rra ref a 10Meg
Cka k a 10p
.ends

.model DBAT85 D (Is=1.5u Rs=1.2 N=1.05 Cjo=10p Eg=0.69 Xti=2)

Vva va 0 5.0

* Topologia 4.9: Diodos BAT85 para VA e GND com R18=1.5k
Vdrv_bat in_bat 0 20.0
R18_bat in_bat ain_bat 1.5k
Vsense va va_bat 0
D_hi ain_bat va_bat DBAT85
D_lo 0 ain_bat DBAT85

* Topologia 4.10B: Clamp Ativo Compensado por Vbe
Vdrv_act in_act 0 20.0
R18_act in_act ain_act 1.5k

R48 va v_ref_hi 12k
R49 v_ref_hi 0 150k
C45 va v_ref_hi 100n
Q9 va v_ref_hi v_bias_hi 2N3904
R50 v_bias_hi 0 6.8k
C46 v_bias_hi 0 100n

R51 va v_ref_lo 150k
R52 v_ref_lo 0 10k
C47 v_ref_lo 0 100n
Q10 0 v_ref_lo v_bias_lo 2N3906
R53 va v_bias_lo 6.8k
C48 v_bias_lo 0 100n

Q11 0 v_bias_hi ain_act 2N3906
Q12 va v_bias_lo ain_act 2N3904

.control
op
print v(ain_bat) i(Vsense) v(ain_act)
quit
.endc
.end
