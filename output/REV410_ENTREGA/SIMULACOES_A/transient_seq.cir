* Transiente Sequencial Completo Rev 4.10A
* Modelos SPICE Padronizados Rev 4.10A
.include "/home/rodrigues/Pedaleira-digital/output/auditoria_rev49/SIMULACOES/OP_STARTUP.lib"

.model 2N3904 NPN (Is=14.34f Bf=255.9 Vaf=74.03 Ikf=.2847 Xtb=1.5 Br=6.092 Cjc=7.306p Cje=22.01p Rb=10 Rc=1)
.model 2N3906 PNP (Is=1.41f Bf=180.7 Vaf=18.7 Ikf=80m Xtb=1.5 Br=4.977 Cjc=9.728p Cje=10.68p Rb=20 Rc=2.4)

.subckt 2N7000 D G S
M1 D G S S NMOS_INT
Cgs G S 30p
Cgd G D 10p
Cds D S 25p
D_body S D DBODY
.model DBODY D(Is=1e-14 Rs=0.5)
.model NMOS_INT NMOS (Level=1 Vto=2.1 Kp=0.25 Rd=1.2 Rs=1.2 Lambda=0.01)
.ends

.model D4148 D(Is=2.5n N=1.75 Rs=.6 Cjo=4p Tt=4n)
.model DBAT85 D(Is=200n N=1.05 Rs=2 Cjo=10p)
.model Dprot D(Is=1p N=1 Rs=1 Cjo=5p)
.model DZ1V8 D(Is=1e-14 Bv=1.8 Ibv=1m N=1)

.subckt TL431 K A REF
Rref REF A 10Meg
Cref REF A 2p
Vref vr A 2.488
Gerr A n_err REF vr 20m
Rerr n_err A 10k
Ccomp n_err A 100p
D_hi n_err v_lim D4148
V_lim v_lim A 4.0
D_lo A n_err D4148
R_b n_err q_b 100
Q_out k_sat q_b A 2N3904
Dz k_sat K DZ1V8
C_k K A 20p
.ends

* --- Supervisor +5VA ---
R33 v5 ref_tl 9.1k
R34 ref_tl 0 11k
R38 va_ok ref_tl 470k
XU7 u7_k 0 ref_tl TL431
Q3 va_ok q3_b v5 2N3906
R35 v5 q3_b 2.2k
R36 q3_b u7_k 1.8k
R37 va_ok 0 22k
C_ok va_ok 0 10p

* --- Intertravamento /RST ---
R39 pd10 codec_rst 1.0k
R13 codec_rst 0 10k
C_codec codec_rst 0 20p
Q1 codec_rst rst_clamp_b 0 2N3904
R40 v33 rst_clamp_b 4.7k
Q2 rst_clamp_b q2_b 0 2N3904
R41 va_ok q2_b 22k

* --- Contenção AIN sem VA ---
D15 n2 d15_k D4148
R43 d15_k v_hold 47
C44 v_hold 0 10u
R45 v_hold shunt_en 47k
R46 shunt_en 0 100k
Q4 shunt_en q4_b 0 2N3904
R44 va_ok q4_b 10k

* Shunts Q5..Q8
XQ5 n9 shunt_en 0 2N7000
XQ6 n8 shunt_en 0 2N7000
R47 n4 q7_d 47
XQ7 q7_d shunt_en 0 2N7000
XQ8 n10 shunt_en 0 2N7000

* --- Front-End Analógico e Polarização ---
R22 n2 n56 2.2k
R23 n56 0 2.2k
C38 n56 0 470u
C39 n56 0 100n

R27 v5 n4 13k
R28 n4 0 12k
C40 n4 0 100u
C41 n4 0 100n
R10 n4 n10 100k
C34 n10 0 100n

XU1A n34 n38 n2 0 n38 TL072
XU3A n38 n30 n2 0 n28 TL072
XU3B n56 n29 n2 0 n27 TL072

C1 n39 n37 100n
R26 n37 n34 1k
R3 n34 n56 1Meg
R17 n30 n28 10k
C18 n30 n28 22p
R18 n28 n7 1.5k
C2 n7 n9 10u
R19 n29 n27 10k
C19 n29 n27 22p
R20 n27 n6 1.5k
C16 n6 n8 10u
R24 n38 n29 10k

R15 n9 n4 100k
R16 n8 n4 100k
C20 n9 n8 680p
C35 n9 0 100p
C36 n8 0 100p
RADC n9 n8 37k

* Diodos de proteção e clamping com sensor de corrente
V_sense_d9 n9_k v5 0
V_sense_d11 n8_k v5 0
D9 n9 n9_k DBAT85
D10 0 n9 DBAT85
D11 n8 n8_k DBAT85
D12 0 n8 DBAT85
Dhi0 n9 v5 Dprot
Dlo0 0 n9 Dprot
Dhi1 n8 v5 Dprot
Dlo1 0 n8 Dprot

V33 v33 0 3.3
Vraw n2 0 PWL(0 0 5m 0 6m 11.3 75m 11.3 80m 0 100m 0)
V5 v5 0 PWL(0 0 18m 0 20m 5.0 60m 5.0 61m 0 100m 0)
Vpd10 pd10 0 PWL(0 0 10m 0 10.01m 3.3 30m 3.3 30.01m 0 35m 0 35.01m 3.3 100m 3.3)
Vguitar n39 0 SIN(0 0.5 1k)

.options reltol=1e-3 abstol=1e-9 trtol=1
.control
tran 50u 95m
wrdata /home/rodrigues/Pedaleira-digital/output/REV410_ENTREGA/SIMULACOES_A/transient_seq.txt v(n2) v(v5) v(va_ok) v(codec_rst) v(v_hold) v(shunt_en) v(n9) v(n8) v(n4) v(n10) i(V_sense_d9) i(V_sense_d11)
quit
.endc
.end
